# Ansys Electronics Desktop project, version 2021.1
materials:
  vacuum: permittivity=1
  Rogers RO4003 (tm): permittivity=3.55 dielectric_loss_tangent=0.0027
  Taconic TLY (tm): permittivity=2.2 dielectric_loss_tangent=0.0009
  copper: permeability=0.999991 conductivity=58000000
  air: permittivity=1.0006 permeability=1.0000004

design HFSSDesign1 (HFSS, DrivenModal, model units mm)
variables:
  h = 1.52mm
  s = 2.8mm
  l = 9.5mm
  wp = 46mm
  ws = 1.88mm
  fx = 8.5mm
  fy = fx
  h1 = 0.8128mm
  l3 = 29.35mm
  a = 23.3mm
  l6 = 5.85mm
  b = 6.145mm
  l5 = 5.52mm
  k2 = 37mm
  d = 0.1mm
  Hs = 1.52mm
  w35 = 3.2mm
geometry:
  Patch = rectangle(corner=(-wp/2, -wp/2, h), x_size=wp, y_size=wp)
  Rectangle3 = rectangle(corner=(-s/2, -wp/2, h), x_size=s, y_size=l)
  Rectangle4 = rectangle(corner=(-s/2, wp/2-l, h), x_size=s, y_size=l)
  Rectangle5 = rectangle(corner=(-wp/2, -s/2, h), x_size=l, y_size=s)
  Rectangle6 = rectangle(corner=(wp/2-l, -s/2, h), x_size=l, y_size=s)
  Patch.subtract(Rectangle3..Rectangle6)
  Substate [Rogers RO4003 (tm)] = box(corner=(-47mm, -40mm, 0), size=(94mm, 80mm, -h1))
  Cylinder1 [copper] = cylinder(axis=Z, base_centre=(fx, fy, h), radius=0.3mm, height=-(h+h1))
  Cylinder1_7 = Cylinder1.copy()
  Cylinder1_8 = Cylinder1.copy()
  Cylinder6 [copper] = cylinder(axis=Z, base_centre=(fx, -fy, h), radius=0.3mm, height=-(h+h1))
  Cylinder6_3 = Cylinder6.copy()
  Cylinder6_4 = Cylinder6.copy()
  Substate.subtract(Cylinder1_8, Cylinder6_4)
  Rectangle13 = rectangle(corner=((-l5/2)-w35, (-l6/2)-ws, -h1), x_size=l5+w35*2, y_size=l6+2*ws)
  Rectangle28 = rectangle(corner=((-l5/2), (-l6/2), -h1), x_size=l5, y_size=l6)
  Rectangle13.subtract(Rectangle28)
  Rectangle15 = rectangle(corner=((l6/2), -10mm, -h1), x_size=ws, y_size=b)
  Rectangle14 = rectangle(corner=((-l6/2), -10mm, -h1), x_size=-ws, y_size=b)
  Rectangle16 = rectangle(corner=((-l6/2), 10mm, -h1), x_size=-ws, y_size=-b)
  Rectangle17 = rectangle(corner=((l6/2), 10mm, -h1), x_size=ws, y_size=-b)
  Rectangle13.unite(Rectangle15, Rectangle14, Rectangle16, Rectangle17)
  Rectangle13.rotate(axis=Z, angle=90deg)
  Rectangle13.move(k2, 0mm, 0mm)
  Rectangle29 = rectangle(corner=(l6/2, -10mm, 0mm), z_size=-h1, x_size=1.88mm)
  Rectangle29.rotate(axis=Z, angle=90deg)
  Rectangle29.move(k2, 0mm, 0mm)
  Rectangle30 = rectangle(corner=(-l6/2+-1.88mm, -10mm, 0mm), z_size=-h1, x_size=1.88mm)
  Rectangle30.rotate(axis=Z, angle=90deg)
  Rectangle30.move(k2, 0mm, 0mm)
  Ground_3 = rectangle(corner=(-47mm, -40mm, 0), x_size=94mm, y_size=80mm)
  Cylinder2 = cylinder(axis=Z, base_centre=(fx, fy, Hs), radius=0.5mm, height=-(Hs+h1))
  Ground_3.subtract(Cylinder2)
  Cylinder13 = cylinder(axis=Z, base_centre=(fx, -fy, Hs), radius=0.5mm, height=-(Hs+h1))
  Ground_3.subtract(Cylinder13)
  Substrate1 [Taconic TLY (tm)] = box(corner=(-47m, -40mm, 0), size=(88mm, 80mm, h))
  Substrate1.subtract(Cylinder1_7, Cylinder6_3)
  Rectangle18 = rectangle(corner=(-10mm+ws, -l6/2-ws, -h1), x_size=-ws, y_size=-l3+l6)
  Rectangle19 = rectangle(corner=(-10mm+ws, l6/2+ws, -h1), x_size=-ws, y_size=l3-l6)
  Rectangle20 = rectangle(corner=(l3-l6/2+ws, 10mm, -h1), x_size=-ws, y_size=27.9mm-fx)
  Rectangle20.rotate(axis=Z, angle=90deg)
  Rectangle21 = rectangle(corner=(l6/2-l3, 10mm, -h1), x_size=-ws, y_size=27.9mm-fx)
  Rectangle21.rotate(axis=Z, angle=90deg)
  Rectangle31 = rectangle(corner=(-10mm+ws-(27.9mm-fx), -fx+0.7mm, -h1), x_size=-ws, y_size=-a+fx+(-l6/2)-ws)
  Rectangle32 = rectangle(corner=(-10mm+ws-(27.9mm-fx), fx-0.7mm, -h1), x_size=-ws, y_size=a-fx-(-l6/2)+ws)
  Rectangle18.unite(Rectangle19, Rectangle20, Rectangle21, Rectangle31, Rectangle32)
  Rectangle18.move(k2, 0mm, 0mm)
  Box1 [air] = box(corner=(-80mm, -80mm, -50mm), size=(160mm, 160mm, 100mm))
  Box1.rotate(axis=Z, angle=90deg)
  Rectangle13.unite(Rectangle18)
boundaries and excitations:
  FiniteCond1: Finite Conductivity Objects=[Ground_3, Patch, Rectangle13] Conductivity=58000000 Permeability=1 IsInternal
  Rad1: Radiation Objects=Box1
  3: Lumped Port Objects=Rectangle29 Modes{Mode1{IntLine{middle of Rectangle29.edge(2 of 4) -> middle of Rectangle29.edge(4 of 4)} CharImp=Zpi RenormImp=50ohm}} Impedance=50ohm
  4: Lumped Port Objects=Rectangle30 Modes{Mode1{IntLine{middle of Rectangle30.edge(2 of 4) -> middle of Rectangle30.edge(4 of 4)} CharImp=Zpi RenormImp=50ohm}} Impedance=50ohm
setups:
  Setup1: HfssDriven Frequency=5.6GHz MaxDeltaS=0.002 MaximumPasses=10 MinimumPasses=1 MinimumConvergedPasses=1 PercentRefinement=30 BasisOrder=1 PortAccuracy=2
    sweep Sweep: 5.2GHz to 6GHz step 0.01GHz; Type=Discrete SaveFields
source amplitudes:
  3:1: 1W 0deg
  4:1: 0W 0deg
radiation setups:
  Infinite Sphere1: Infinite Sphere Theta=-180deg..180deg step 2deg Phi=-180deg..180deg step 2deg
field plots:
  Vector_Jsurf1: Jsurf over Patch.face(at (0, 0, 1.52)) on Setup1 : LastAdaptive at Freq=5.6GHz Phase=135deg
reports:
  S Parameter Plot 1: dB(S(4,3)), dB(S(4,4)) vs Freq on Setup1 : Sweep; markers MY1 at y=-10
  Axial Ratio Plot 1: dB(AxialRatioValue) vs Freq on Setup1 : Sweep, Infinite Sphere1 [Theta=0deg Phi=0deg]; markers m1 at 5.6375GHz, m2 at 5.6GHz
  Gain Plot 1: dB(GainTotal) vs Freq on Setup1 : Sweep, Infinite Sphere1 [Phi=0deg Theta=0deg]; markers m1 at 5.6GHz, m2 at 5.6375GHz
  Gain Plot 10: dB(RealizedGainTotal) vs Phi, Theta on Setup1 : Sweep, Infinite Sphere1 [Freq=5.6GHz]
  Gain Plot 20: dB(GainLHCP), dB(GainRHCP) vs Theta on Setup1 : Sweep, Infinite Sphere1 [Phi=0deg Freq=5.6375GHz a=23.3mm l6=5.85mm b=all l5=5.52mm]
  Gain Plot 21: dB(GainLHCP), dB(GainRHCP) vs Theta on Setup1 : LastAdaptive, Infinite Sphere1 [Phi=0deg Freq=5.5GHz]
  Gain Plot 22: dB(GainTotal) vs Phi, Theta on Setup1 : Sweep, Infinite Sphere1 [Freq=5.6GHz l=9.5mm wp=46mm fx=8.5mm]
  Gain Plot 23: dB(GainTotal) vs Phi, Theta on Setup1 : Sweep, Infinite Sphere1 [Freq=5.5GHz]
  Gain Plot 24: dB(GainTotal) vs Phi, Theta on Setup1 : Sweep, Infinite Sphere1 [Freq=5.6GHz]
  Gain Plot 25: dB(GainLHCP), dB(GainRHCP) vs Theta on Setup1 : Sweep, Infinite Sphere1 [Phi=0deg,90deg Freq=5.6GHz s=all]
  Realized Gain Plot 1: dB(RealizedGainLHCP), dB(RealizedGainRHCP) vs Theta on Setup1 : Sweep, Infinite Sphere1 [Phi=0deg,90deg Freq=5.6GHz]
  Realized Gain Plot 2: dB(GainLHCP) vs Theta on Setup1 : Sweep, Infinite Sphere1 [Phi=44deg Freq=5.6GHz s=all]
  S Parameter Plot 2: dB(S(3,4)) vs Freq on Setup1 : Sweep [l=all]
  S Parameter Plot 3: dB(S(4,4)) vs Freq on Setup1 : Sweep [l=all]
  Gain Plot 26: dB(GainLHCP), dB(GainRHCP) vs Theta on Setup1 : LastAdaptive, Infinite Sphere1 [Phi=0deg,90deg Freq=5.6GHz]

design HFSSDesign2 (HFSS, DrivenModal, model units mm)
variables:
  h = 1.52mm
  s = 2.8mm
  l = 9.5mm
  wp = 46mm
  ws = 1.88mm
  fx = 8.5mm
  fy = fx
  h1 = 0.8128mm
  l3 = 29.35mm
  a = 23.3mm
  l6 = 5.85mm
  b = 6.145mm
  l5 = 5.52mm
  k2 = 37mm
  d = 0.1mm
  Hs = 1.52mm
  w35 = 3.2mm
  Ha = 0mm
geometry:
  Patch = rectangle(corner=(-wp/2, -wp/2, h), x_size=wp, y_size=wp)
  Rectangle3 = rectangle(corner=(-s/2, -wp/2, h), x_size=s, y_size=l)
  Rectangle4 = rectangle(corner=(-s/2, wp/2-l, h), x_size=s, y_size=l)
  Rectangle5 = rectangle(corner=(-wp/2, -s/2, h), x_size=l, y_size=s)
  Rectangle6 = rectangle(corner=(wp/2-l, -s/2, h), x_size=l, y_size=s)
  Patch.subtract(Rectangle3..Rectangle6)
  Substate [Rogers RO4003 (tm)] = box(corner=(-47mm, -40mm, 0), size=(94mm, 80mm, -h1))
  Cylinder1 [copper] = cylinder(axis=Z, base_centre=(fx, fy, h), radius=0.3mm, height=-(h+h1))
  Cylinder1_7 = Cylinder1.copy()
  Cylinder1_8 = Cylinder1.copy()
  Cylinder6 [copper] = cylinder(axis=Z, base_centre=(fx, -fy, h), radius=0.3mm, height=-(h+h1))
  Cylinder6_3 = Cylinder6.copy()
  Cylinder6_4 = Cylinder6.copy()
  Substate.subtract(Cylinder1_8, Cylinder6_4)
  Rectangle13 = rectangle(corner=((-l5/2)-w35, (-l6/2)-ws, -h1), x_size=l5+w35*2, y_size=l6+2*ws)
  Rectangle28 = rectangle(corner=((-l5/2), (-l6/2), -h1), x_size=l5, y_size=l6)
  Rectangle13.subtract(Rectangle28)
  Rectangle15 = rectangle(corner=((l6/2), -10mm, -h1), x_size=ws, y_size=b)
  Rectangle14 = rectangle(corner=((-l6/2), -10mm, -h1), x_size=-ws, y_size=b)
  Rectangle16 = rectangle(corner=((-l6/2), 10mm, -h1), x_size=-ws, y_size=-b)
  Rectangle17 = rectangle(corner=((l6/2), 10mm, -h1), x_size=ws, y_size=-b)
  Rectangle13.unite(Rectangle15, Rectangle14, Rectangle16, Rectangle17)
  Rectangle13.rotate(axis=Z, angle=90deg)
  Rectangle13.move(k2, 0mm, 0mm)
  Ground_3 = rectangle(corner=(-47mm, -40mm, 0), x_size=94mm, y_size=80mm)
  Cylinder2 = cylinder(axis=Z, base_centre=(fx, fy, Hs), radius=0.5mm, height=-(Hs+h1))
  Ground_3.subtract(Cylinder2)
  Cylinder13 = cylinder(axis=Z, base_centre=(fx, -fy, Hs), radius=0.5mm, height=-(Hs+h1))
  Ground_3.subtract(Cylinder13)
  Substrate1 [Taconic TLY (tm)] = box(corner=(-47m, -40mm, 0), size=(94mm, 80mm, h))
  Substrate1.subtract(Cylinder1_7, Cylinder6_3)
  Rectangle18 = rectangle(corner=(-10mm+ws, -l6/2-ws, -h1), x_size=-ws, y_size=-l3+l6)
  Rectangle19 = rectangle(corner=(-10mm+ws, l6/2+ws, -h1), x_size=-ws, y_size=l3-l6)
  Rectangle20 = rectangle(corner=(l3-l6/2+ws, 10mm, -h1), x_size=-ws, y_size=27.9mm-fx)
  Rectangle20.rotate(axis=Z, angle=90deg)
  Rectangle21 = rectangle(corner=(l6/2-l3, 10mm, -h1), x_size=-ws, y_size=27.9mm-fx)
  Rectangle21.rotate(axis=Z, angle=90deg)
  Rectangle31 = rectangle(corner=(-10mm+ws-(27.9mm-fx), -fx+0.7mm, -h1), x_size=-ws, y_size=-a+fx+(-l6/2)-ws)
  Rectangle32 = rectangle(corner=(-10mm+ws-(27.9mm-fx), fx-0.7mm, -h1), x_size=-ws, y_size=a-fx-(-l6/2)+ws)
  Rectangle18.unite(Rectangle19, Rectangle20, Rectangle21, Rectangle31, Rectangle32)
  Rectangle18.move(k2, 0mm, 0mm)
  Box1 [air] = box(corner=(-80mm, -80mm, -50mm), size=(160mm, 160mm, 100mm))
  Box1.rotate(axis=Z, angle=90deg)
  Rectangle13.unite(Rectangle18)
  [Substrate1, Patch].move(0mm, 0mm, Ha)
boundaries and excitations:
  FiniteCond1: Finite Conductivity Objects=[Ground_3, Patch, Rectangle13] Conductivity=58000000 Permeability=1 IsInternal
  Rad1: Radiation Objects=Box1
setups:
  Setup1: HfssDriven Frequency=5.6GHz MaxDeltaE=0.1 MaximumPasses=10 MinimumPasses=1 MinimumConvergedPasses=1 PercentRefinement=30 BasisOrder=1
    sweep Sweep: 5.2GHz to 6GHz step 0.01GHz; Type=Discrete SaveFields
radiation setups:
  Infinite Sphere1: Infinite Sphere Theta=-180deg..180deg step 2deg Phi=-180deg..180deg step 2deg
field plots:
  Vector_Jsurf1: Jsurf over Patch.face(#16) on Setup1 : LastAdaptive at Freq=5.6GHz Phase=135deg
reports:
  S Parameter Plot 1: dB(S(4,3)), dB(S(4,4)) vs Freq on Setup1 : Sweep; markers MY1 at y=-10
  Axial Ratio Plot 1: dB(AxialRatioValue) vs Freq on Setup1 : Sweep, Infinite Sphere1 [Theta=0deg Phi=0deg]; markers m1 at 5.6375GHz, m2 at 5.6GHz
  Gain Plot 1: dB(GainTotal) vs Freq on Setup1 : Sweep, Infinite Sphere1 [Phi=0deg Theta=0deg]; markers m1 at 5.6GHz, m2 at 5.6375GHz
  Gain Plot 10: dB(GainTotal) vs Phi, Theta on Setup1 : Sweep, Infinite Sphere1 [Freq=5.45GHz l=9.5mm wp=46mm fx=8.5mm]
  Gain Plot 20: dB(GainLHCP), dB(GainRHCP) vs Theta on Setup1 : Sweep, Infinite Sphere1 [Phi=0deg Freq=5.6375GHz a=23.3mm l6=5.85mm b=all l5=5.52mm]
  Gain Plot 21: dB(GainLHCP), dB(GainRHCP) vs Theta on Setup1 : LastAdaptive, Infinite Sphere1 [Phi=0deg Freq=5.5GHz]
  Gain Plot 22: dB(GainTotal) vs Phi, Theta on Setup1 : Sweep, Infinite Sphere1 [Freq=5.6GHz l=9.5mm wp=46mm fx=8.5mm]
  Gain Plot 23: dB(GainTotal) vs Phi, Theta on Setup1 : Sweep, Infinite Sphere1 [Freq=5.5GHz]
  Gain Plot 24: dB(GainTotal) vs Phi, Theta on Setup1 : Sweep, Infinite Sphere1 [Freq=5.6GHz]
  Gain Plot 25: dB(GainLHCP), dB(GainRHCP) vs Theta on Setup1 : Sweep, Infinite Sphere1 [Phi=0deg,90deg Freq=5.6GHz s=all]
  Realized Gain Plot 1: dB(RealizedGainLHCP), dB(RealizedGainRHCP) vs Theta on Setup1 : Sweep, Infinite Sphere1 [Phi=0deg,90deg Freq=5.6GHz]
  Realized Gain Plot 2: dB(GainLHCP) vs Theta on Setup1 : Sweep, Infinite Sphere1 [Phi=44deg Freq=5.6GHz s=all]
  S Parameter Plot 2: dB(S(3,4)) vs Freq on Setup1 : Sweep [l=all]
  S Parameter Plot 3: dB(S(4,4)) vs Freq on Setup1 : Sweep [l=all]
  Gain Plot 26: dB(GainLHCP), dB(GainRHCP) vs Theta on Setup1 : LastAdaptive, Infinite Sphere1 [Phi=0deg,90deg Freq=5.6GHz]
